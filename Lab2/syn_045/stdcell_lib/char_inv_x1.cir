* ==========================================

* INV_X1 Characterization (Stable Version)

* ==========================================

* Technology + models

.include /CMC/setups/ensc450/HSPICE/cmosp18/rules.inc

.LIB '/CMC/setups/ensc450/HSPICE/cmosp18/log018.l' SS

.option post

.option method=gear

.option reltol=1e-3

* Include your inverter definition

.include inv_x1.inc

* Worst case conditions (Lab spec)

.param pwr=1.05

.temp 125

Vvdd  vdd  0   dc pwr

Vvdds vdds 0   dc pwr

Vgnd  gnd  0   dc 0

Vgnds gnds 0   dc 0

* Load capacitance (X1 requirement: 10–20 fF)

Cload z 0 10f

* Input stimulus (0.5ns transition)

VA a 0 PWL(0n 0 5n 0 5.5n pwr 15n pwr)

* Instantiate cell

Xinv a z vdd vdds gnd gnds INV_X1

* Transient analysis (stable timestep)

.tran 10ps 20ns

* Measurements

.meas tran tpdf TRIG v(a) val='pwr*0.5' RISE=1

+ TARG v(z) val='pwr*0.5' FALL=1

.meas tran leak_pow avg power FROM=1ns TO=4ns

.meas tran dyn_pow avg power FROM=5ns TO=7ns

.end
