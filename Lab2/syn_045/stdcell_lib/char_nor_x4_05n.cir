* ==========================================

* NOR_X4 Characterization (0.5ns slew)

* ==========================================

.include /CMC/setups/ensc450/HSPICE/cmosp18/rules.inc

.LIB '/CMC/setups/ensc450/HSPICE/cmosp18/log018.l' SS

.option post

.option method=gear

.option reltol=1e-3

.include nor_x4.inc

.param pwr=1.05

.temp 125

Vvdd  vdd  0   dc pwr

Vvdds vdds 0   dc pwr

Vgnd  gnd  0   dc 0

Vgnds gnds 0   dc 0

* Hold B = 0 so NOR behaves like inverter on A

Vb b 0 dc 0

.param Cload=20f

Cload z 0 Cload

* 0.5ns slew

Va a 0 PWL(0n 0 5n 0 5.5n pwr 10n pwr 10.5n 0 15n 0)

Xnor a b z vdd vdds gnd gnds NOR_X4

.tran 10ps 20ns sweep Cload START=20f STOP=80f STEP=20f

.meas tran tpdf TRIG v(a) val='pwr*0.5' RISE=1

+ TARG v(z) val='pwr*0.5' FALL=1

.meas tran tpdr TRIG v(a) val='pwr*0.5' FALL=1

+ TARG v(z) val='pwr*0.5' RISE=1

.meas tran leak_pow avg power FROM=1ns TO=4ns

.meas tran dyn_pow  avg power FROM=5ns TO=8ns

.end
